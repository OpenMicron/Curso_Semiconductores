* Extracted by KLayout with SKY130 LVS runset on : 04/06/2026 00:17

* cell OTA_5T
* pin sky130_gnd
.SUBCKT OTA_5T sky130_gnd
* device instance $1 r0 *1 -1.955,5.68 sky130_fd_pr__pfet_01v8
XM$1 \$29 \$I149 \$23 \$I72 sky130_fd_pr__pfet_01v8 L=1000000 W=12000000
+ AS=3.6e+12 AD=1.8e+12 PS=25200000 PD=12600000
* device instance $2 r0 *1 -0.655,5.68 sky130_fd_pr__pfet_01v8
XM$2 \$23 \$33 \$25 \$I72 sky130_fd_pr__pfet_01v8 L=1000000 W=24000000
+ AS=3.6e+12 AD=3.6e+12 PS=25200000 PD=25200000
* device instance $4 r0 *1 1.945,5.68 sky130_fd_pr__pfet_01v8
XM$4 \$23 \$I160 \$29 \$I72 sky130_fd_pr__pfet_01v8 L=1000000 W=12000000
+ AS=1.8e+12 AD=3.6e+12 PS=12600000 PD=25200000
* device instance $9 r0 *1 -1.955,-2.695 sky130_fd_pr__nfet_01v8
XM$9 \$8 \$I101 \$1 sky130_gnd sky130_fd_pr__nfet_01v8 L=1000000 W=3000000
+ AS=900000000000 AD=450000000000 PS=6600000 PD=3300000
* device instance $10 r0 *1 -0.655,-2.695 sky130_fd_pr__nfet_01v8
XM$10 \$1 \$I95 \$22 sky130_gnd sky130_fd_pr__nfet_01v8 L=1000000 W=3000000
+ AS=450000000000 AD=450000000000 PS=3300000 PD=3300000
* device instance $11 r0 *1 0.645,-2.695 sky130_fd_pr__nfet_01v8
XM$11 \$22 \$I93 \$1 sky130_gnd sky130_fd_pr__nfet_01v8 L=1000000 W=3000000
+ AS=450000000000 AD=450000000000 PS=3300000 PD=3300000
* device instance $12 r0 *1 1.945,-2.695 sky130_fd_pr__nfet_01v8
XM$12 \$1 \$I98 \$8 sky130_gnd sky130_fd_pr__nfet_01v8 L=1000000 W=3000000
+ AS=450000000000 AD=900000000000 PS=3300000 PD=6600000
* device instance $13 r0 *1 -1.955,-6.425 sky130_fd_pr__nfet_01v8
XM$13 \$11 \$I101 \$5 sky130_gnd sky130_fd_pr__nfet_01v8 L=1000000 W=3000000
+ AS=900000000000 AD=450000000000 PS=6600000 PD=3300000
* device instance $14 r0 *1 -0.655,-6.425 sky130_fd_pr__nfet_01v8
XM$14 \$5 \$I95 \$4 sky130_gnd sky130_fd_pr__nfet_01v8 L=1000000 W=3000000
+ AS=450000000000 AD=450000000000 PS=3300000 PD=3300000
* device instance $15 r0 *1 0.645,-6.425 sky130_fd_pr__nfet_01v8
XM$15 \$4 \$I93 \$5 sky130_gnd sky130_fd_pr__nfet_01v8 L=1000000 W=3000000
+ AS=450000000000 AD=450000000000 PS=3300000 PD=3300000
* device instance $16 r0 *1 1.945,-6.425 sky130_fd_pr__nfet_01v8
XM$16 \$5 \$I98 \$13 sky130_gnd sky130_fd_pr__nfet_01v8 L=1000000 W=3000000
+ AS=450000000000 AD=900000000000 PS=3300000 PD=6600000
* device instance $17 r0 *1 4.835,-2.945 sky130_fd_pr__nfet_01v8
XM$17 \$14 \$I137 \$6 sky130_gnd sky130_fd_pr__nfet_01v8 L=1000000 W=2500000
+ AS=750000000000 AD=375000000000 PS=5600000 PD=2800000
* device instance $18 r0 *1 6.135,-2.945 sky130_fd_pr__nfet_01v8
XM$18 \$6 \$I146 \$9 sky130_gnd sky130_fd_pr__nfet_01v8 L=1000000 W=2500000
+ AS=375000000000 AD=750000000000 PS=2800000 PD=5600000
* device instance $19 r0 *1 -6.145,-2.945 sky130_fd_pr__nfet_01v8
XM$19 \$20 \$I138 \$15 sky130_gnd sky130_fd_pr__nfet_01v8 L=1000000 W=2500000
+ AS=750000000000 AD=375000000000 PS=5600000 PD=2800000
* device instance $20 r0 *1 -4.845,-2.945 sky130_fd_pr__nfet_01v8
XM$20 \$15 \$I147 \$16 sky130_gnd sky130_fd_pr__nfet_01v8 L=1000000 W=2500000
+ AS=375000000000 AD=750000000000 PS=2800000 PD=5600000
* device instance $21 r0 *1 4.835,-6.175 sky130_fd_pr__nfet_01v8
XM$21 \$10 \$I137 \$18 sky130_gnd sky130_fd_pr__nfet_01v8 L=1000000 W=2500000
+ AS=750000000000 AD=375000000000 PS=5600000 PD=2800000
* device instance $22 r0 *1 6.135,-6.175 sky130_fd_pr__nfet_01v8
XM$22 \$18 \$I146 \$2 sky130_gnd sky130_fd_pr__nfet_01v8 L=1000000 W=2500000
+ AS=375000000000 AD=750000000000 PS=2800000 PD=5600000
* device instance $23 r0 *1 -6.145,-6.175 sky130_fd_pr__nfet_01v8
XM$23 \$7 \$I138 \$21 sky130_gnd sky130_fd_pr__nfet_01v8 L=1000000 W=2500000
+ AS=750000000000 AD=375000000000 PS=5600000 PD=2800000
* device instance $24 r0 *1 -4.845,-6.175 sky130_fd_pr__nfet_01v8
XM$24 \$21 \$I147 \$17 sky130_gnd sky130_fd_pr__nfet_01v8 L=1000000 W=2500000
+ AS=375000000000 AD=750000000000 PS=2800000 PD=5600000
* device instance $25 r0 *1 3.39,5.68 sky130_fd_pr__pfet_01v8
XM$25 \$23 \$I66 \$23 \$I72 sky130_fd_pr__pfet_01v8 L=150000 W=12000000
+ AS=3.6e+12 AD=3.6e+12 PS=25200000 PD=25200000
* device instance $26 r0 *1 -3.4,5.68 sky130_fd_pr__pfet_01v8
XM$26 \$23 \$I67 \$23 \$I72 sky130_fd_pr__pfet_01v8 L=150000 W=12000000
+ AS=3.6e+12 AD=3.6e+12 PS=25200000 PD=25200000
* device instance $27 r0 *1 3.39,-6.425 sky130_fd_pr__nfet_01v8
XM$27 \$5 \$I103 \$5 sky130_gnd sky130_fd_pr__nfet_01v8 L=150000 W=3000000
+ AS=900000000000 AD=900000000000 PS=6600000 PD=6600000
* device instance $28 r0 *1 -3.4,-6.425 sky130_fd_pr__nfet_01v8
XM$28 \$5 \$I104 \$5 sky130_gnd sky130_fd_pr__nfet_01v8 L=150000 W=3000000
+ AS=900000000000 AD=900000000000 PS=6600000 PD=6600000
* device instance $29 r0 *1 3.39,-2.695 sky130_fd_pr__nfet_01v8
XM$29 \$1 \$I103 \$1 sky130_gnd sky130_fd_pr__nfet_01v8 L=150000 W=3000000
+ AS=900000000000 AD=900000000000 PS=6600000 PD=6600000
* device instance $30 r0 *1 -3.4,-2.695 sky130_fd_pr__nfet_01v8
XM$30 \$1 \$I104 \$1 sky130_gnd sky130_fd_pr__nfet_01v8 L=150000 W=3000000
+ AS=900000000000 AD=900000000000 PS=6600000 PD=6600000
.ENDS OTA_5T
