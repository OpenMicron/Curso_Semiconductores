* Extracted by KLayout with SKY130 LVS runset on : 06/06/2026 23:47

* cell inv1X
* pin VDD!
* pin Y
* pin VSS!
* pin A
.SUBCKT inv1X VDD! Y VSS! A
* device instance $1 r0 *1 0.5,1.13 sky130_fd_pr__pfet_01v8
XM$1 VDD! A Y VDD! sky130_fd_pr__pfet_01v8 L=150000 W=840000 AS=252000000000
+ AD=252000000000 PS=2280000 PD=2280000
* device instance $2 r0 *1 0.5,-1.2 sky130_fd_pr__nfet_01v8
XM$2 VSS! A Y VSS! sky130_fd_pr__nfet_01v8 L=150000 W=420000 AS=126000000000
+ AD=126000000000 PS=1440000 PD=1440000
.ENDS inv1X
