** sch_path: /foss/designs/Curso_Semiconductores/LDO/LDO.sch
.subckt LDO VIN IBias VREF VOUT VFB1 VFB2 VSS
*.PININFO VIN:B VREF:B VFB1:B VSS:B VFB2:B VOUT:B IBias:B
XM7 VOUT Vgate VIN VIN sky130_fd_pr__pfet_01v8 L=0.15 W=6 nf=1 m=50
XC3 Vgate VOUT sky130_fd_pr__model__cap_mim W=10 L=10
x1 VIN Vgate VREF VFB1 IBias VSS OTA_5T
x2 VOUT VFB2 VSS RES_FB
.ends

* expanding   symbol:  /foss/designs/Curso_Semiconductores/OTA_5T/OTA_5T.sym # of pins=6
** sym_path: /foss/designs/Curso_Semiconductores/OTA_5T/OTA_5T.sym
** sch_path: /foss/designs/Curso_Semiconductores/OTA_5T/OTA_5T.sch
.subckt OTA_5T VIN VOUT_AMP VINN VINP IB VSS
*.PININFO VIN:B VSS:B VOUT_AMP:B IB:B VINN:B VINP:B
XM1 IB IB VSS VSS sky130_fd_pr__nfet_01v8 L=1 W=2.5 nf=1 m=4
XM2 tail IB VSS VSS sky130_fd_pr__nfet_01v8 L=1 W=2.5 nf=1 m=4
XM3 net1 VINP tail VSS sky130_fd_pr__nfet_01v8 L=1 W=3 nf=1 m=4
XM4 VOUT_AMP VINN tail VSS sky130_fd_pr__nfet_01v8 L=1 W=3 nf=1 m=4
XM5 VOUT_AMP net1 VIN VIN sky130_fd_pr__pfet_01v8 L=1 W=6 nf=1 m=4
XM6 net1 net1 VIN VIN sky130_fd_pr__pfet_01v8 L=1 W=6 nf=1 m=4
XM8 tail VSS tail VSS sky130_fd_pr__nfet_01v8 L=0.15 W=3 nf=1 m=4
XM7 VIN VIN VIN VIN sky130_fd_pr__pfet_01v8 L=0.15 W=6 nf=1 m=4
.ends

* expanding   symbol:  /foss/designs/Curso_Semiconductores/RES_FB/RES_FB.sym # of pins=3
** sym_path: /foss/designs/Curso_Semiconductores/RES_FB/RES_FB.sym
** sch_path: /foss/designs/Curso_Semiconductores/RES_FB/RES_FB.sch
.subckt RES_FB VOUT VFB VSS
*.PININFO VOUT:B VFB:B VSS:B
XR11 net1 VOUT VSS sky130_fd_pr__res_xhigh_po_0p69 L=8.62 mult=1
XR1 VFB net1 VSS sky130_fd_pr__res_xhigh_po_0p69 L=8.62 mult=1
XR2 net8 VFB VSS sky130_fd_pr__res_xhigh_po_0p69 L=8.62 mult=1
XR3 net4 net8 VSS sky130_fd_pr__res_xhigh_po_0p69 L=8.62 mult=1
XR4 net2 net4 VSS sky130_fd_pr__res_xhigh_po_0p69 L=8.62 mult=1
XR5 net5 net2 VSS sky130_fd_pr__res_xhigh_po_0p69 L=8.62 mult=1
XR6 net3 net5 VSS sky130_fd_pr__res_xhigh_po_0p69 L=8.62 mult=1
XR7 net7 net3 VSS sky130_fd_pr__res_xhigh_po_0p69 L=8.62 mult=1
XR8 net6 net7 VSS sky130_fd_pr__res_xhigh_po_0p69 L=8.62 mult=1
XR9 VSS net6 VSS sky130_fd_pr__res_xhigh_po_0p69 L=8.62 mult=1
.ends
