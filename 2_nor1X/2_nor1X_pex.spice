* SPICE3 file created from 2_nor1X.ext - technology: sky130A

.subckt x2_nor1X A B Y VDD! VSS!
X0 Y.t2 A a_n169_122.t0 VDD!.t0 sky130_fd_pr__pfet_01v8 ad=0.126 pd=1.14 as=0.126 ps=1.14 w=0.84 l=0.15
X1 VSS!.t0 A Y.t1 VSUBS sky130_fd_pr__nfet_01v8 ad=0.126 pd=1.44 as=0.063 ps=0.72 w=0.42 l=0.15
X2 a_n169_122.t3 B VDD_uq0.t0 VDD!.t3 sky130_fd_pr__pfet_01v8 ad=0.126 pd=1.14 as=0.126 ps=1.14 w=0.84 l=0.15
X3 Y.t3 B VSS!.t1 VSUBS sky130_fd_pr__nfet_01v8 ad=0.063 pd=0.72 as=0.126 ps=1.44 w=0.42 l=0.15
X4 VDD_uq0.t1 B a_n169_122.t2 VDD!.t2 sky130_fd_pr__pfet_01v8 ad=0.126 pd=1.14 as=0.252 ps=2.28 w=0.84 l=0.15
X5 a_n169_122.t1 A Y.t0 VDD!.t1 sky130_fd_pr__pfet_01v8 ad=0.252 pd=2.28 as=0.126 ps=1.14 w=0.84 l=0.15
C0 m1_n196_368# VDD! 0.01394f
C1 Y A 0.05215f
C2 B VDD! 0.13116f
C3 Y m1_n196_n460# 0.02698f
C4 Y VDD! 0.04128f
C5 VSS! B 0.01753f
C6 A VDD! 0.13116f
C7 VSS! Y 0.0682f
C8 VSS! A 0.01731f
C9 VSS! m1_n196_n460# 0.11314f
C10 Y B 0.02132f
C11 B A 0.072f
R0 VSS!.t0 VSS!.n0 316.899
R1 VSS! VSS!.n0 21.8488
R2 VSS!.n0 VSS!.t1 277.175
R3 Y.n0 Y.t3 42.8576
R4 Y.n0 Y.t1 42.8576
R5 Y Y.n0 194.638
R6 Y Y.n1 336.817
R7 Y.n1 Y.t2 35.1791
R8 Y.n1 Y.t0 35.1791
R9 VDD_uq0.n0 VDD_uq0.t1 35.1791
R10 VDD_uq0.n0 VDD_uq0.t0 35.1791
R11 VDD! VDD_uq0.n0 372.548
R12 a_n169_122.t1 a_n169_122.n1 356.67
R13 a_n169_122.n1 a_n169_122.n0 297.182
R14 a_n169_122.n0 a_n169_122.t3 35.1791
R15 a_n169_122.n0 a_n169_122.t0 35.1791
R16 a_n169_122.n1 a_n169_122.t2 356.67
R17 VDD!.n0 VDD! 102.835
R18 VDD! VDD!.t2 235.053
R19 VDD!.t2 VDD!.t3 220.362
R20 VDD!.t3 VDD!.t0 220.362
R21 VDD!.t0 VDD!.t1 220.362
C12 m1_n196_n460# VSUBS 0.16515f
C13 m1_n196_368# VSUBS 0.13805f
C14 VSS! VSUBS 0.29619f
C15 Y VSUBS 0.4619f
C16 A VSUBS 0.22116f
C17 B VSUBS 0.22116f
C18 VDD! VSUBS 0.95596f
C19 VDD!.n0 VSUBS 0.01624f
C20 VDD!.t2 VSUBS 0.07191f
C21 VDD!.t3 VSUBS 0.06959f
C22 VDD!.t0 VSUBS 0.06959f
C23 VDD!.t1 VSUBS 0.1415f
C24 a_n169_122.t1 VSUBS 0.06825f
C25 a_n169_122.t2 VSUBS 0.06825f
C26 a_n169_122.n0 VSUBS 0.03946f
C27 a_n169_122.t3 VSUBS 0.01944f
C28 a_n169_122.t0 VSUBS 0.01944f
C29 a_n169_122.n1 VSUBS 0.38544f
C30 VDD_uq0.t0 VSUBS 0.02036f
C31 VDD_uq0.n0 VSUBS 0.06223f
C32 VDD_uq0.t1 VSUBS 0.02036f
C33 Y.n0 VSUBS 0.01969f
C34 Y.n1 VSUBS 0.04334f
C35 Y.t2 VSUBS 0.01878f
C36 Y.t0 VSUBS 0.01878f
C37 VSS!.t0 VSUBS 0.03704f
C38 VSS!.t1 VSUBS 0.02504f
C39 VSS!.n0 VSUBS 0.15142f
.ends
