* SPICE3 file created from 3_nor1X.ext - technology: sky130A

.subckt x3_nor1X A B C Y VDD! VSS!
X0 a_153_596.t3 A VDD_uq0.t2 VDD!.t8 sky130_fd_pr__pfet_01v8 ad=0.126 pd=1.14 as=0.126 ps=1.14 w=0.84 l=0.15
X1 VDD_uq0.t1 A a_153_596.t5 VDD!.t7 sky130_fd_pr__pfet_01v8 ad=0.126 pd=1.14 as=0.126 ps=1.14 w=0.84 l=0.15
X2 a_153_596.t4 A VDD_uq0.t0 VDD!.t6 sky130_fd_pr__pfet_01v8 ad=0.126 pd=1.14 as=0.252 ps=2.28 w=0.84 l=0.15
X3 Y.t4 C VSS!.t1 VSUBS sky130_fd_pr__nfet_01v8 ad=0.126 pd=1.44 as=0.063 ps=0.72 w=0.42 l=0.15
X4 VSS!.t0 B Y.t0 VSUBS sky130_fd_pr__nfet_01v8 ad=0.063 pd=0.72 as=0.063 ps=0.72 w=0.42 l=0.15
X5 Y.t5 A VSS!.t2 VSUBS sky130_fd_pr__nfet_01v8 ad=0.063 pd=0.72 as=0.126 ps=1.44 w=0.42 l=0.15
X6 Y.t3 C a_423_596.t5 VDD!.t5 sky130_fd_pr__pfet_01v8 ad=0.252 pd=2.28 as=0.126 ps=1.14 w=0.84 l=0.15
X7 a_423_596.t4 C Y.t1 VDD!.t4 sky130_fd_pr__pfet_01v8 ad=0.126 pd=1.14 as=0.126 ps=1.14 w=0.84 l=0.15
X8 Y.t2 C a_423_596.t3 VDD!.t3 sky130_fd_pr__pfet_01v8 ad=0.126 pd=1.14 as=0.126 ps=1.14 w=0.84 l=0.15
X9 a_423_596.t2 B a_153_596.t2 VDD!.t2 sky130_fd_pr__pfet_01v8 ad=0.126 pd=1.14 as=0.126 ps=1.14 w=0.84 l=0.15
X10 a_153_596.t1 B a_423_596.t1 VDD!.t1 sky130_fd_pr__pfet_01v8 ad=0.126 pd=1.14 as=0.126 ps=1.14 w=0.84 l=0.15
X11 a_423_596.t0 B a_153_596.t0 VDD!.t0 sky130_fd_pr__pfet_01v8 ad=0.126 pd=1.14 as=0.126 ps=1.14 w=0.84 l=0.15
C0 A VDD! 0.19534f
C1 m1_36_14# Y 0.15998f
C2 B VSS! 0.01452f
C3 VSS! VDD! 0.01368f
C4 m1_36_842# VDD! 0.02495f
C5 B VDD! 0.17999f
C6 VSS! Y 0.12953f
C7 VSS! C 0.01465f
C8 m1_36_842# Y 0.01777f
C9 B Y 0.01753f
C10 B C 0.0744f
C11 Y VDD! 0.07176f
C12 C VDD! 0.19534f
C13 m1_36_14# VSS! 0.1985f
C14 VSS! A 0.01959f
C15 Y C 0.09791f
C16 B A 0.0744f
R0 VSS!.t0 VSS!.n0 42.8576
R1 VSS!.n0 VSS!.t1 42.8576
R2 VSS! VSS!.n1 70.6212
R3 VSS!.n1 VSS!.n0 274.043
R4 VSS!.n1 VSS!.t2 277.175
R5 Y.n0 Y.t5 42.8576
R6 Y.n0 Y.t0 42.8576
R7 Y.n1 Y.n0 194.689
R8 Y Y.n1 0.845328
R9 Y Y.n2 27.4371
R10 Y.n2 Y.n3 392.113
R11 Y.n3 Y.t2 35.1791
R12 Y.n3 Y.t1 35.1791
R13 Y.n2 Y.t3 383.474
R14 Y.n1 Y.t4 237.157
R15 a_423_596.t4 a_423_596.n0 35.1791
R16 a_423_596.n0 a_423_596.t5 35.1791
R17 a_423_596.n0 a_423_596.n3 309.289
R18 a_423_596.n3 a_423_596.n2 308.8
R19 a_423_596.n2 a_423_596.t2 35.1791
R20 a_423_596.n2 a_423_596.t3 35.1791
R21 a_423_596.n3 a_423_596.n1 309.291
R22 a_423_596.n1 a_423_596.t0 35.1791
R23 a_423_596.n1 a_423_596.t1 35.1791
R24 a_153_596.n0 a_153_596.n3 309.291
R25 a_153_596.n0 a_153_596.t1 35.1791
R26 a_153_596.t2 a_153_596.n0 35.1791
R27 a_153_596.n3 a_153_596.n2 308.801
R28 a_153_596.n2 a_153_596.t3 35.1791
R29 a_153_596.n2 a_153_596.t0 35.1791
R30 a_153_596.n3 a_153_596.n1 309.289
R31 a_153_596.n1 a_153_596.t4 35.1791
R32 a_153_596.n1 a_153_596.t5 35.1791
R33 VDD_uq0.n1 VDD_uq0.n0 390.425
R34 VDD_uq0.t1 VDD_uq0.n0 35.1791
R35 VDD_uq0.n0 VDD_uq0.t2 35.1791
R36 VDD! VDD_uq0.n1 11.035
R37 VDD_uq0.n1 VDD_uq0.t0 409.827
R38 VDD!.n0 VDD! 105.284
R39 VDD! VDD!.t6 232.603
R40 VDD!.t6 VDD!.t7 220.362
R41 VDD!.t7 VDD!.t8 220.362
R42 VDD!.t8 VDD!.t0 220.362
R43 VDD!.t0 VDD!.t1 220.362
R44 VDD!.t1 VDD!.t2 220.362
R45 VDD!.t2 VDD!.t3 220.362
R46 VDD!.t3 VDD!.t4 220.362
R47 VDD!.t4 VDD!.t5 220.362
C17 m1_36_14# VSUBS 0.27874f
C18 m1_36_842# VSUBS 0.23968f
C19 VSS! VSUBS 0.47132f
C20 Y VSUBS 0.43055f
C21 C VSUBS 0.29081f
C22 B VSUBS 0.15194f
C23 A VSUBS 0.29081f
C24 VDD! VSUBS 1.2304f
C25 VDD!.n0 VSUBS 0.01809f
C26 VDD!.t6 VSUBS 0.07784f
C27 VDD!.t7 VSUBS 0.07574f
C28 VDD!.t8 VSUBS 0.07574f
C29 VDD!.t0 VSUBS 0.07574f
C30 VDD!.t1 VSUBS 0.07574f
C31 VDD!.t2 VSUBS 0.07574f
C32 VDD!.t3 VSUBS 0.07574f
C33 VDD!.t4 VSUBS 0.07574f
C34 VDD!.t5 VSUBS 0.154f
C35 VDD_uq0.t1 VSUBS 0.01765f
C36 VDD_uq0.n0 VSUBS 0.07929f
C37 VDD_uq0.t0 VSUBS 0.06833f
C38 VDD_uq0.n1 VSUBS 0.43588f
C39 VDD_uq0.t2 VSUBS 0.01765f
C40 a_153_596.t2 VSUBS 0.02812f
C41 a_153_596.n0 VSUBS 0.05917f
C42 a_153_596.n1 VSUBS 0.05917f
C43 a_153_596.t4 VSUBS 0.02812f
C44 a_153_596.t5 VSUBS 0.02812f
C45 a_153_596.n2 VSUBS 0.05899f
C46 a_153_596.t3 VSUBS 0.02812f
C47 a_153_596.t0 VSUBS 0.02812f
C48 a_153_596.n3 VSUBS 0.36305f
C49 a_153_596.t1 VSUBS 0.02812f
C50 a_423_596.t4 VSUBS 0.02751f
C51 a_423_596.n0 VSUBS 0.05788f
C52 a_423_596.n1 VSUBS 0.05788f
C53 a_423_596.t0 VSUBS 0.02751f
C54 a_423_596.t1 VSUBS 0.02751f
C55 a_423_596.n2 VSUBS 0.0577f
C56 a_423_596.t2 VSUBS 0.02751f
C57 a_423_596.t3 VSUBS 0.02751f
C58 a_423_596.n3 VSUBS 0.35513f
C59 a_423_596.t5 VSUBS 0.02751f
C60 Y.n0 VSUBS 0.01979f
C61 Y.t4 VSUBS 0.03325f
C62 Y.n1 VSUBS 0.21674f
C63 Y.t3 VSUBS 0.0692f
C64 Y.n2 VSUBS 0.14787f
C65 Y.n3 VSUBS 0.05283f
C66 Y.t2 VSUBS 0.01885f
C67 Y.t1 VSUBS 0.01885f
C68 VSS!.n0 VSUBS 0.04581f
C69 VSS!.t2 VSUBS 0.02824f
C70 VSS!.n1 VSUBS 0.27603f
.ends
