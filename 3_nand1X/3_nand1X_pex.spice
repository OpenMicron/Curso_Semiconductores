* SPICE3 file created from 3_nand1X.ext - technology: sky130A

.subckt x3_nand1X A C B Y VDD! VSS!
X0 VDD_uq0.t1 C a_147_710.t0 VDD!.t1 sky130_fd_pr__pfet_01v8 ad=0.189 pd=1.86 as=0.0945 ps=0.93 w=0.63 l=0.15
X1 a_147_710.t1 C VDD_uq0.t0 VDD!.t0 sky130_fd_pr__pfet_01v8 ad=0.0945 pd=0.93 as=0.0945 ps=0.93 w=0.63 l=0.15
X2 VDD_uq0.t5 B a_147_710.t6 VDD!.t5 sky130_fd_pr__pfet_01v8 ad=0.0945 pd=0.93 as=0.0945 ps=0.93 w=0.63 l=0.15
X3 a_147_710.t5 B VDD_uq0.t4 VDD!.t4 sky130_fd_pr__pfet_01v8 ad=0.0945 pd=0.93 as=0.0945 ps=0.93 w=0.63 l=0.15
X4 VSS!.t0 C a_372_244.t0 VSUBS sky130_fd_pr__nfet_01v8 ad=0.126 pd=1.44 as=0.063 ps=0.72 w=0.42 l=0.15
X5 a_372_244.t1 B a_282_244.t1 VSUBS sky130_fd_pr__nfet_01v8 ad=0.063 pd=0.72 as=0.063 ps=0.72 w=0.42 l=0.15
X6 VDD_uq0.t3 A a_147_710.t3 VDD!.t3 sky130_fd_pr__pfet_01v8 ad=0.0945 pd=0.93 as=0.0945 ps=0.93 w=0.63 l=0.15
X7 a_282_244.t0 A a_147_710.t4 VSUBS sky130_fd_pr__nfet_01v8 ad=0.063 pd=0.72 as=0.126 ps=1.44 w=0.42 l=0.15
X8 a_147_710.t2 A VDD_uq0.t2 VDD!.t2 sky130_fd_pr__pfet_01v8 ad=0.0945 pd=0.93 as=0.189 ps=1.86 w=0.63 l=0.15
C0 C B 0.08448f
C1 C VDD! 0.15481f
C2 B A 0.08448f
C3 VSS! VDD! 0.01545f
C4 m1_30_86# VSS! 0.15345f
C5 m1_30_914# VDD! 0.01799f
C6 C VSS! 0.0198f
C7 VDD! A 0.15481f
C8 B VDD! 0.14123f
R0 VSS!.t0 VSS! 368.099
R1 a_372_244.t0 a_372_244.t1 85.7148
R2 a_282_244.t0 a_282_244.t1 85.7148
R3 a_147_710.t4 a_147_710.n1 238.812
R4 a_147_710.n1 a_147_710.n3 0.388431
R5 a_147_710.n3 a_147_710.n4 594.688
R6 a_147_710.n4 a_147_710.t1 46.9053
R7 a_147_710.n4 a_147_710.t0 46.9053
R8 a_147_710.n3 a_147_710.n2 594.301
R9 a_147_710.n2 a_147_710.t5 46.9053
R10 a_147_710.n2 a_147_710.t6 46.9053
R11 a_147_710.n1 a_147_710.n0 594.301
R12 a_147_710.n0 a_147_710.t2 46.9053
R13 a_147_710.n0 a_147_710.t3 46.9053
R14 VDD_uq0.t1 VDD_uq0.n4 728.852
R15 VDD! VDD_uq0.n0 4.85567
R16 VDD_uq0.n0 VDD_uq0.n2 39.7246
R17 VDD_uq0.n2 VDD_uq0.n4 39.7246
R18 VDD_uq0.n4 VDD_uq0.n3 642.225
R19 VDD_uq0.n3 VDD_uq0.t5 46.9053
R20 VDD_uq0.n3 VDD_uq0.t0 46.9053
R21 VDD_uq0.n2 VDD_uq0.n1 642.225
R22 VDD_uq0.n1 VDD_uq0.t3 46.9053
R23 VDD_uq0.n1 VDD_uq0.t4 46.9053
R24 VDD_uq0.n0 VDD_uq0.t2 689.129
R25 VDD!.n0 VDD! 173.84
R26 VDD! VDD!.t2 164.047
R27 VDD!.t2 VDD!.t3 220.362
R28 VDD!.t3 VDD!.t4 220.362
R29 VDD!.t4 VDD!.t5 220.362
R30 VDD!.t5 VDD!.t0 220.362
R31 VDD!.t0 VDD!.t1 220.362
C9 m1_30_86# VSUBS 0.20929f
C10 m1_30_914# VSUBS 0.17971f
C11 VSS! VSUBS 0.5331f
C12 C VSUBS 0.22142f
C13 B VSUBS 0.12124f
C14 A VSUBS 0.22142f
C15 VDD! VSUBS 0.92436f
C16 VDD!.n0 VSUBS 0.03202f
C17 VDD!.t2 VSUBS 0.07082f
C18 VDD!.t3 VSUBS 0.08119f
C19 VDD!.t4 VSUBS 0.08119f
C20 VDD!.t5 VSUBS 0.08119f
C21 VDD!.t0 VSUBS 0.08119f
C22 VDD!.t1 VSUBS 0.16509f
C23 VDD_uq0.t1 VSUBS 0.05302f
C24 VDD_uq0.t2 VSUBS 0.04783f
C25 VDD_uq0.n0 VSUBS 0.07815f
C26 VDD_uq0.t3 VSUBS 0.01208f
C27 VDD_uq0.t4 VSUBS 0.01208f
C28 VDD_uq0.n1 VSUBS 0.02627f
C29 VDD_uq0.n2 VSUBS 0.10483f
C30 VDD_uq0.t5 VSUBS 0.01208f
C31 VDD_uq0.t0 VSUBS 0.01208f
C32 VDD_uq0.n3 VSUBS 0.02627f
C33 VDD_uq0.n4 VSUBS 0.19485f
C34 a_147_710.t4 VSUBS 0.03312f
C35 a_147_710.t2 VSUBS 0.01361f
C36 a_147_710.t3 VSUBS 0.01361f
C37 a_147_710.n0 VSUBS 0.02746f
C38 a_147_710.n1 VSUBS 0.34095f
C39 a_147_710.t5 VSUBS 0.01361f
C40 a_147_710.t6 VSUBS 0.01361f
C41 a_147_710.n2 VSUBS 0.02746f
C42 a_147_710.n3 VSUBS 0.1566f
C43 a_147_710.t1 VSUBS 0.01361f
C44 a_147_710.t0 VSUBS 0.01361f
C45 a_147_710.n4 VSUBS 0.02751f
C46 VSS!.t0 VSUBS 0.06758f
.ends
