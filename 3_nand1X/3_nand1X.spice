** sch_path: /foss/designs/Curso_Semiconductores/3_nand1X/3_nand1X.sch
.subckt 3_nand1X A C B Y VDD! VSS!
*.PININFO A:I B:I C:I Y:O VDD!:B VSS!:B
XM1 Y A VDD! VDD! sky130_fd_pr__pfet_01v8 L=0.15 W=0.63 nf=1 m=2
XM2 Y A net1 VSS! sky130_fd_pr__nfet_01v8 L=0.15 W=0.42 nf=1
XM5 net1 B net2 VSS! sky130_fd_pr__nfet_01v8 L=0.15 W=0.42 nf=1
XM6 net2 C VSS! VSS! sky130_fd_pr__nfet_01v8 L=0.15 W=0.42 nf=1
XM3 Y B VDD! VDD! sky130_fd_pr__pfet_01v8 L=0.15 W=0.63 nf=1 m=2
XM4 Y C VDD! VDD! sky130_fd_pr__pfet_01v8 L=0.15 W=0.63 nf=1 m=2
.ends
